| z11b.ibs * IBIS 5.0 Model
| 8Gb DDR4 SDRAM - Die Revision "E"
| This Model is valid for Commercial Temperature Range 0C<=Tc<=95C
| Valid for DDR4-1600/1866/2133/2400/2666/2933/3200 operation
| Models *_3200 are applicable for speed grade 3200 Mbps (-062) and below
| Part Number   VDD/VDDQ   Architecture   Package
| MT40A2G4SA   1.2V/1.2V   2Gb   x 4   78-Ball FBGA
| MT40A1G8SA   1.2V/1.2V   1Gb   x 8   78-Ball FBGA
| MT40A512M16LY   1.2V/1.2V   512Mb x 16   96-Ball FBGA
| MT40A2G4Z11B   1.2V/1.2V   2Gb   x 4   Bare Die
| MT40A1G8Z11B   1.2V/1.2V   1Gb   x 8   Bare Die
| MT40A512M16Z11B   1.2V/1.2V   512Mb x 16   Bare Die
[IBIS Ver]   5.0
[File Name]   z11b_sm.ibs
[Date]   2/27/2023
[File Rev]   2.9.2
[Source]   From silicon level SPICE model at Micron Technology, Inc.
   For support contact your local Micron FAE/Sales contacts
   (more information at https://www.micron.com/support/sales-network)
[Notes]   Revision History:
   Rev 2.9.2: 2/27/2023
   - Updated bare die components and pin mapping tables
   Rev 2.9.1: 8/12/2022
   - Added Industrial and Automotive Temperature Ranges to release
   Rev 2.9: 8/7/2022
   - Added pin mapping sections to bare die components according to
   8/15/2016 padlog
   Rev 2.8.2: 1/11/2021
   - Created the Industrial Temperature Range version of the model
   Rev 2.8.1: 8/20/2020
   - Updated x16 package component and sparse matrix model
   Rev 2.8: 7/28/2020
   - Updated c_comp with 6/9/2020 IOCAP measurements
   - Updated x4 and x8 package configuration based on 7/21/2020 data
   Rev 2.7: 5/8/2020
   - Updated c_comp with 9/5/2019 IOCAP measurements
   - Used new script to generate DQ driver models
   Rev 2.6: 8/23/2019
   - Corrected ondie decoupling capacitor models
   Rev 2.5: 7/2/2019
   - Fixed ISSO tables
   - Matched C_comp with latest (5/23/2019) IOCAP measurements
   Rev 2.4: 2/11/2019
   - Matched C_comp with latest IOCAP measurements
   - Matched IV curves with latest silicon measurements
   Rev 2.3: 7/12/2018
   - Matched C_comp with latest IOCAP measurements
   - Matched IV curves with latest silicon measurements
   Rev 2.2: 06/20/2018
   - Added separate Automotive Temp (AT) model.
   Rev 2.1: 06/04/2018
   - Added separate Industrial Temp (IT) model.
   Rev 2.0: 9/22/2017
   - Matched C_comp with latest IOCAP measurements
   - Matched IV curves with latest silicon measurements
   Rev 1.0: 12/12/2016
   - Initial pre-silicon model
   - Model data extracted from HSPICE model revision 1.0
   Notes:
   - The DQ_IN_ODT* models contain assumed input thresholds,
   the actual threshold values will depend on the VREFDQ
   level set by training
   - This IBIS file uses the Submodel keyword to model the
   DDR4 On-die Termination(ODT) characteristics.
   - The C_comp value in the DQ I/O model is set to match the
   input state of the DQ I/O as measured from the HSPICE model.
   The C_comp value decreases in the DQ/DQS Input ODT models.
   - L_pin values in the Pin sections are loop inductance and
   include the mutual inductance to appropriate POWER/GND
   return paths.  POWER/GND parasitics are modeled in the
   Package Models.
   - Typ and slow corner V-t curves in the following DQ* models
   are shifted relative to strong corner V-t curve
   to contain all 3 corners within appropriate V-t window
   Models   Typ   Slow   V-t duration
   DQ*_34_3200   -100ps   -250ps   500ps
   DQ*_40_3200   -100ps   -250ps   500ps
   DQ*_48_3200   -100ps   -250ps   500ps
   ALERT_3200   -70ps   -180ps   500ps
   - Due to the shift in typ and slow corner, the V-t curves
   may overlap each other. This does not effect the accuracy
   of the IBIS data.
   - The NF_INPUT Model is for Non-functioning pins in the x4
   package
   - The NF_DQ Model is for Non-functioning DQ pins in the
   x4 package
   See Micron IBIS Model Quality Report and Quality Checklist
   for full IQ details
[Disclaimer]  This software code and all associated documentation, comments
              or other information (collectively "Software") is provided
              "AS IS" without warranty of any kind. MICRON TECHNOLOGY, INC.
              ("MTI") EXPRESSLY DISCLAIMS ALL WARRANTIES EXPRESS OR IMPLIED,
              INCLUDING BUT NOT LIMITED TO, NONINFRINGEMENT OF THIRD PARTY
              RIGHTS, AND ANY IMPLIED WARRANTIES OF MERCHANTABILITY OR
              FITNESS FOR ANY PARTICULAR PURPOSE. MTI DOES NOT WARRANT THAT
              THE SOFTWARE WILL MEET YOUR REQUIREMENTS, OR THAT THE
              OPERATION OF THE SOFTWARE WILL BE UNINTERRUPTED OR ERROR-FREE.
              FURTHERMORE, MTI DOES NOT MAKE ANY REPRESENTATIONS REGARDING
              THE USE OR THE RESULTS OF THE USE OF THE SOFTWARE IN TERMS OF
              ITS CORRECTNESS, ACCURACY, RELIABILITY, OR OTHERWISE. THE
              ENTIRE RISK ARISING OUT OF USE OR PERFORMANCE OF THE SOFTWARE
              REMAINS WITH YOU. IN NO EVENT SHALL MTI, ITS AFFILIATED
              COMPANIES OR THEIR SUPPLIERS BE LIABLE FOR ANY DIRECT,
              INDIRECT, CONSEQUENTIAL, INCIDENTAL, OR SPECIAL DAMAGES
              (INCLUDING, WITHOUT LIMITATION, DAMAGES FOR LOSS OF PROFITS,
              BUSINESS INTERRUPTION, OR LOSS OF INFORMATION) ARISING OUT OF
              YOUR USE OF OR INABILITY TO USE THE SOFTWARE, EVEN IF MTI HAS
              BEEN ADVISED OF THE POSSIBILITY OF SUCH DAMAGES. Because some
              jurisdictions prohibit the exclusion or limitation of
              liability for consequential or incidental damages, the above
              limitation may not apply to you.
[Copyright]   Copyright 2022 Micron Technology, Inc. All rights reserved.
| COMPONENT: MT40A2G4SA (78-Ball FBGA, x4)
[Component]   MT40A2G4SA
[Package Model] z11b_78ball_pkg
[Manufacturer]  Micron Technology,Inc.
[Package]
|   typ   min   max
R_pkg   0.420   0.337   0.508
L_pkg   1.872nH   1.600nH   2.256nH
C_pkg   0.503pF   0.373pF   0.869pF
[Pin]   signal_name   model_name   R_pin   L_pin   C_pin   | TD_pin(ps)   Z_pin
A1   VDD   POWER
A2   VSS   GND
A3   NF   NF_DQ   0.468   1.674nH   0.508pF   | 29.160   57.411
A7   NF   NF_DQ   0.479   1.742nH   0.585pF   | 31.921   54.584
A8   VSS   GND
A9   VSS   GND
B1   VPP   POWER
B2   VDDQ   POWER
B3   DQS_D_c   DQS   0.483   1.679nH   0.529pF   | 29.803   56.344
B7   DQ_D1   DQ   0.467   1.632nH   0.584pF   | 30.879   52.837
B8   VDDQ   POWER
B9   ZQ   NC
C1   VDDQ   POWER
C2   DQ_D0   DQ   0.469   1.610nH   0.574pF   | 30.404   52.960
C3   DQS_D_t   DQS   0.475   1.798nH   0.476pF   | 29.260   61.450
C7   VDD   POWER
C8   VSS   GND
C9   VDDQ   POWER
D1   VSS   GND
D2   NC   NC
D3   DQ_D2   DQ   0.471   1.737nH   0.510pF   | 29.758   58.380
D7   DQ_D3   DQ   0.464   1.678nH   0.578pF   | 31.131   53.899
D8   NC   NC
D9   VSS   GND
E1   VSSL   GND
E2   VDDQ   POWER
E3   NC   NC
E7   NC   NC
E8   VDDQ   POWER
E9   VSS   GND
F1   VDDL   POWER
F2   NC   NC
F3   ODT   INPUT   0.423   2.049nH   0.469pF   | 30.987   66.123
F7   CK_t   CLKIN   0.424   1.731nH   0.474pF   | 28.640   60.452
F8   CK_c   CLKIN   0.419   1.671nH   0.528pF   | 29.696   56.277
F9   VDD   POWER
G1   VSS   GND
G2   NC   NC
G3   CKE   INPUT   0.417   2.095nH   0.424pF   | 29.791   70.324
G7   CS_n   INPUT   0.417   1.902nH   0.442pF   | 29.003   65.579
G8   NC   NC
G9   TEN   INPUT   0.402   2.078nH   0.888pF   | 42.963   48.376
H1   VDD   POWER
H2   WE_n_A14   INPUT   0.406   2.014nH   0.473pF   | 30.864   65.258
H3   ACT_n   INPUT   0.408   1.881nH   0.419pF   | 28.078   66.976
H7   CAS_n_A15   INPUT   0.405   1.965nH   0.393pF   | 27.777   70.734
H8   RAS_n_A16   INPUT   0.412   1.989nH   0.479pF   | 30.861   64.442
H9   VSS   GND
J1   VREFCA   POWER
J2   BG0   INPUT   0.406   1.898nH   0.453pF   | 29.337   64.694
J3   A10   INPUT   0.406   1.830nH   0.393pF   | 26.827   68.213
J7   A12_BC_n   INPUT   0.406   1.941nH   0.378pF   | 27.084   71.672
J8   BG1   INPUT   0.418   2.042nH   0.470pF   | 30.983   65.919
J9   VDD   POWER
K1   VSS   GND
K2   BA0   INPUT   0.409   1.979nH   0.487pF   | 31.052   63.720
K3   A4   INPUT   0.407   1.854nH   0.438pF   | 28.491   65.085
K7   A3   INPUT   0.405   1.944nH   0.427pF   | 28.818   67.441
K8   BA1   INPUT   0.406   2.024nH   0.474pF   | 30.975   65.344
K9   VSS   GND
L1   RESET_n   INPUT   0.352   1.673nH   0.740pF   | 35.197   47.547
L2   A6   INPUT   0.405   1.847nH   0.490pF   | 30.073   61.424
L3   A0   INPUT   0.405   1.689nH   0.426pF   | 26.827   62.951
L7   A1   INPUT   0.409   1.872nH   0.430pF   | 28.361   66.019
L8   A5   INPUT   0.410   1.932nH   0.502pF   | 31.135   62.058
L9   ALERT_n   ALERT   0.348   1.777nH   0.723pF   | 35.847   49.561
M1   VDD   POWER
M2   A8   INPUT   0.409   1.918nH   0.485pF   | 30.505   62.883
M3   A2   INPUT   0.414   1.875nH   0.410pF   | 27.733   67.600
M7   A9   INPUT   0.411   1.946nH   0.399pF   | 27.864   69.857
M8   A7   INPUT   0.410   1.997nH   0.497pF   | 31.507   63.393
M9   VPP   POWER
N1   VSS   GND
N2   A11   INPUT   0.405   1.872nH   0.506pF   | 30.765   60.840
N3   PARITY   INPUT   0.411   1.710nH   0.481pF   | 28.673   59.651
N7   NC   NC
N8   A13   INPUT   0.416   2.062nH   0.486pF   | 31.647   65.172
N9   VDD   POWER
|***********************PIN MAPPING*****************************************
[Pin Mapping]   pulldown_ref   pullup_ref   gnd_clamp_ref   power_clamp_ref ext_ref
A1   NC   VDD
A2   VSS   NC
A3   NC   NC   VSS   VDDQ
A7   NC   NC   VSS   VDDQ
A8   VSS   NC
A9   VSS   NC
B1   NC   VPP
B2   NC   VDDQ
B3   VSS   VDDQ   VSS   VDDQ
B7   VSS   VDDQ   VSS   VDDQ
B8   NC   VDDQ
B9   NC   NC
C1   NC   VDDQ
C2   VSS   VDDQ   VSS   VDDQ
C3   VSS   VDDQ   VSS   VDDQ
C7   NC   VDD
C8   VSS   NC
C9   NC   VDDQ
D1   VSS   NC
D2   NC   NC
D3   VSS   VDDQ   VSS   VDDQ
D7   VSS   VDDQ   VSS   VDDQ
D8   NC   NC
D9   VSS   NC
E1   VSSL   NC
E2   NC   VDDQ
E3   NC   NC
E7   NC   NC
E8   NC   VDDQ
E9   VSS   NC
F1   NC   VDDL
F2   NC   NC
F3   NC   NC   VSS   VDD
F7   NC   NC   VSS   VDD
F8   NC   NC   VSS   VDD
F9   NC   VDD
G1   VSS   NC
G2   NC   NC
G3   NC   NC   VSS   VDD
G7   NC   NC   VSS   VDD
G8   NC   NC
G9   NC   NC   VSS   VDD
H1   NC   VDD
H2   NC   NC   VSS   VDD
H3   NC   NC   VSS   VDD
H7   NC   NC   VSS   VDD
H8   NC   NC   VSS   VDD
H9   VSS   NC
J1   NC   VREFCA
J2   NC   NC   VSS   VDD
J3   NC   NC   VSS   VDD
J7   NC   NC   VSS   VDD
J8   NC   NC   VSS   VDD
J9   NC   VDD
K1   VSS   NC
K2   NC   NC   VSS   VDD
K3   NC   NC   VSS   VDD
K7   NC   NC   VSS   VDD
K8   NC   NC   VSS   VDD
K9   VSS   NC
L1   NC   NC   VSS   VDD
L2   NC   NC   VSS   VDD
L3   NC   NC   VSS   VDD
L7   NC   NC   VSS   VDD
L8   NC   NC   VSS   VDD
L9   VSS   VDDQ   VSS   VDDQ
M1   NC   VDD
M2   NC   NC   VSS   VDD
M3   NC   NC   VSS   VDD
M7   NC   NC   VSS   VDD
M8   NC   NC   VSS   VDD
M9   NC   VPP
N1   VSS   NC
N2   NC   NC   VSS   VDD
N3   NC   NC   VSS   VDD
N7   NC   NC
N8   NC   NC   VSS   VDD
N9   NC   VDD
|**********************DIFF PIN*********************************************
[Diff_pin]   inv_pin   vdiff   tdelay_typ   tdelay_min   tdelay_max
   C3   B3   0.000V   0ns   NA   NA
   F7   F8   0.250V   0ns   NA   NA
| COMPONENT: MT40A1G8SA (78-Ball FBGA, x8)
[Component]   MT40A1G8SA
[Package Model] z11b_78ball_pkg
[Manufacturer]  Micron Technology,Inc.
[Package]
|   typ   min   max
R_pkg   0.420   0.337   0.508
L_pkg   1.872nH   1.600nH   2.256nH
C_pkg   0.503pF   0.373pF   0.869pF
[Pin]   signal_name   model_name   R_pin   L_pin   C_pin   | TD_pin(ps)   Z_pin
A1   VDD   POWER
A2   VSS   GND
A3   TDQS_D_c   TDQS   0.468   1.674nH   0.508pF   | 29.160   57.411
A7   DM_n_DBI_n_TDQS_t DM_DBI_TDQS_D   0.479   1.742nH   0.585pF   | 31.921   54.584
A8   VSS   GND
A9   VSS   GND
B1   VPP   POWER
B2   VDDQ   POWER
B3   DQS_D_c   DQS   0.483   1.679nH   0.529pF   | 29.803   56.344
B7   DQ_D1   DQ   0.467   1.632nH   0.584pF   | 30.879   52.837
B8   VDDQ   POWER
B9   ZQ   NC
C1   VDDQ   POWER
C2   DQ_D0   DQ   0.469   1.610nH   0.574pF   | 30.404   52.960
C3   DQS_D_t   DQS   0.475   1.798nH   0.476pF   | 29.260   61.450
C7   VDD   POWER
C8   VSS   GND
C9   VDDQ   POWER
D1   VSS   GND
D2   DQ_D4   DQ   0.484   1.646nH   0.583pF   | 30.984   53.119
D3   DQ_D2   DQ   0.471   1.737nH   0.510pF   | 29.758   58.380
D7   DQ_D3   DQ   0.464   1.678nH   0.578pF   | 31.131   53.899
D8   DQ_D5   DQ   0.467   1.577nH   0.552pF   | 29.512   53.455
D9   VSS   GND
E1   VSSL   GND
E2   VDDQ   POWER
E3   DQ_D6   DQ   0.466   1.677nH   0.573pF   | 30.994   54.107
E7   DQ_D7   DQ   0.468   1.704nH   0.570pF   | 31.158   54.677
E8   VDDQ   POWER
E9   VSS   GND
F1   VDDL   POWER
F2   NC   NC
F3   ODT   INPUT   0.423   2.049nH   0.469pF   | 30.987   66.123
F7   CK_t   CLKIN   0.424   1.731nH   0.474pF   | 28.640   60.452
F8   CK_c   CLKIN   0.419   1.671nH   0.528pF   | 29.696   56.277
F9   VDD   POWER
G1   VSS   GND
G2   NC   NC
G3   CKE   INPUT   0.417   2.095nH   0.424pF   | 29.791   70.324
G7   CS_n   INPUT   0.417   1.902nH   0.442pF   | 29.003   65.579
G8   NC   NC
G9   TEN   INPUT   0.402   2.078nH   0.888pF   | 42.963   48.376
H1   VDD   POWER
H2   WE_n_A14   INPUT   0.406   2.014nH   0.473pF   | 30.864   65.258
H3   ACT_n   INPUT   0.408   1.881nH   0.419pF   | 28.078   66.976
H7   CAS_n_A15   INPUT   0.405   1.965nH   0.393pF   | 27.777   70.734
H8   RAS_n_A16   INPUT   0.412   1.989nH   0.479pF   | 30.861   64.442
H9   VSS   GND
J1   VREFCA   POWER
J2   BG0   INPUT   0.406   1.898nH   0.453pF   | 29.337   64.694
J3   A10   INPUT   0.406   1.830nH   0.393pF   | 26.827   68.213
J7   A12_BC_n   INPUT   0.406   1.941nH   0.378pF   | 27.084   71.672
J8   BG1   INPUT   0.418   2.042nH   0.470pF   | 30.983   65.919
J9   VDD   POWER
K1   VSS   GND
K2   BA0   INPUT   0.409   1.979nH   0.487pF   | 31.052   63.720
K3   A4   INPUT   0.407   1.854nH   0.438pF   | 28.491   65.085
K7   A3   INPUT   0.405   1.944nH   0.427pF   | 28.818   67.441
K8   BA1   INPUT   0.406   2.024nH   0.474pF   | 30.975   65.344
K9   VSS   GND
L1   RESET_n   INPUT   0.352   1.673nH   0.740pF   | 35.197   47.547
L2   A6   INPUT   0.405   1.847nH   0.490pF   | 30.073   61.424
L3   A0   INPUT   0.405   1.689nH   0.426pF   | 26.827   62.951
L7   A1   INPUT   0.409   1.872nH   0.430pF   | 28.361   66.019
L8   A5   INPUT   0.410   1.932nH   0.502pF   | 31.135   62.058
L9   ALERT_n   ALERT   0.348   1.777nH   0.723pF   | 35.847   49.561
M1   VDD   POWER
M2   A8   INPUT   0.409   1.918nH   0.485pF   | 30.505   62.883
M3   A2   INPUT   0.414   1.875nH   0.410pF   | 27.733   67.600
M7   A9   INPUT   0.411   1.946nH   0.399pF   | 27.864   69.857
M8   A7   INPUT   0.410   1.997nH   0.497pF   | 31.507   63.393
M9   VPP   POWER
N1   VSS   GND
N2   A11   INPUT   0.405   1.872nH   0.506pF   | 30.765   60.840
N3   PARITY   INPUT   0.411   1.710nH   0.481pF   | 28.673   59.651
N7   NC   NC
N8   A13   INPUT   0.416   2.062nH   0.486pF   | 31.647   65.172
N9   VDD   POWER
|***********************PIN MAPPING*****************************************
[Pin Mapping]   pulldown_ref   pullup_ref   gnd_clamp_ref   power_clamp_ref ext_ref
A1   NC   VDD
A2   VSS   NC
A3   VSS   VDDQ   VSS   VDDQ
A7   VSS   VDDQ   VSS   VDDQ
A8   VSS   NC
A9   VSS   NC
B1   NC   VPP
B2   NC   VDDQ
B3   VSS   VDDQ   VSS   VDDQ
B7   VSS   VDDQ   VSS   VDDQ
B8   NC   VDDQ
B9   NC   NC
C1   NC   VDDQ
C2   VSS   VDDQ   VSS   VDDQ
C3   VSS   VDDQ   VSS   VDDQ
C7   NC   VDD
C8   VSS   NC
C9   NC   VDDQ
D1   VSS   NC
D2   VSS   VDDQ   VSS   VDDQ
D3   VSS   VDDQ   VSS   VDDQ
D7   VSS   VDDQ   VSS   VDDQ
D8   VSS   VDDQ   VSS   VDDQ
D9   VSS   NC
E1   VSSL   NC
E2   NC   VDDQ
E3   VSS   VDDQ   VSS   VDDQ
E7   VSS   VDDQ   VSS   VDDQ
E8   NC   VDDQ
E9   VSS   NC
F1   NC   VDDL
F2   NC   NC
F3   NC   NC   VSS   VDD
F7   NC   NC   VSS   VDD
F8   NC   NC   VSS   VDD
F9   NC   VDD
G1   VSS   NC
G2   NC   NC
G3   NC   NC   VSS   VDD
G7   NC   NC   VSS   VDD
G8   NC   NC
G9   NC   NC   VSS   VDD
H1   NC   VDD
H2   NC   NC   VSS   VDD
H3   NC   NC   VSS   VDD
H7   NC   NC   VSS   VDD
H8   NC   NC   VSS   VDD
H9   VSS   NC
J1   NC   VREFCA
J2   NC   NC   VSS   VDD
J3   NC   NC   VSS   VDD
J7   NC   NC   VSS   VDD
J8   NC   NC   VSS   VDD
J9   NC   VDD
K1   VSS   NC
K2   NC   NC   VSS   VDD
K3   NC   NC   VSS   VDD
K7   NC   NC   VSS   VDD
K8   NC   NC   VSS   VDD
K9   VSS   NC
L1   NC   NC   VSS   VDD
L2   NC   NC   VSS   VDD
L3   NC   NC   VSS   VDD
L7   NC   NC   VSS   VDD
L8   NC   NC   VSS   VDD
L9   VSS   VDDQ   VSS   VDDQ
M1   NC   VDD
M2   NC   NC   VSS   VDD
M3   NC   NC   VSS   VDD
M7   NC   NC   VSS   VDD
M8   NC   NC   VSS   VDD
M9   NC   VPP
N1   VSS   NC
N2   NC   NC   VSS   VDD
N3   NC   NC   VSS   VDD
N7   NC   NC
N8   NC   NC   VSS   VDD
N9   NC   VDD
|**********************DIFF PIN*********************************************
[Diff_pin]   inv_pin   vdiff   tdelay_typ   tdelay_min   tdelay_max
   C3   B3   0.000V   0ns   NA   NA
   F7   F8   0.250V   0ns   NA   NA
| COMPONENT: MT40A512M16LY (96-Ball FBGA, x16)
[Component]   MT40A512M16LY
[Package Model] z11b_96ball_pkg
[Manufacturer]  Micron Technology,Inc.
[Package]
|   typ   min   max
R_pkg   0.430   0.345   0.519
L_pkg   1.948nH   1.288nH   2.760nH
C_pkg   0.475pF   0.369pF   0.665pF
[Pin]   signal_name   model_name   R_pin   L_pin   C_pin   | TD_pin(ps)   Z_pin
A1   VDDQ   POWER
A2   VSS   GND
A3   DQ_D8   DQ   0.435   1.708nH   0.506pF   | 29.401   58.101
A7   UDQS_D_c   DQS   0.435   1.613nH   0.548pF   | 29.732   54.261
A8   VSS   GND
A9   VDDQ   POWER
B1   VPP   POWER
B2   VSS   GND
B3   VDD   POWER
B7   UDQS_D_t   DQS   0.431   1.698nH   0.455pF   | 27.789   61.095
B8   DQ_D9   DQ   0.444   1.692nH   0.500pF   | 29.079   58.204
B9   VDD   POWER
C1   VDDQ   POWER
C2   DQ_D12   DQ   0.434   1.644nH   0.464pF   | 27.614   59.539
C3   DQ_D10   DQ   0.432   1.660nH   0.426pF   | 26.574   62.453
C7   DQ_D11   DQ   0.432   1.597nH   0.468pF   | 27.330   58.445
C8   DQ_D13   DQ   0.449   1.676nH   0.511pF   | 29.275   57.258
C9   VSS   GND
D1   VDD   POWER
D2   VSS   GND
D3   DQ_D14   DQ   0.417   1.687nH   0.434pF   | 27.043   62.363
D7   DQ_D15   DQ   0.434   1.590nH   0.548pF   | 29.510   53.883
D8   VSS   GND
D9   VDDQ   POWER
E1   VSS   GND
E2   UDM_n_UDBI_n   DM_DBI_D   0.434   1.573nH   0.520pF   | 28.600   54.992
E3   VSS   GND
E7   LDM_n_LDBI_n   DM_DBI_D   0.384   1.446nH   0.429pF   | 24.892   58.070
E8   VSS   GND
E9   VSS   GND
F1   VSS   GND
F2   VDDQ   POWER
F3   LDQS_D_c   DQS   0.375   1.350nH   0.426pF   | 23.993   56.264
F7   DQ_D1   DQ   0.378   1.373nH   0.457pF   | 25.047   54.807
F8   VDDQ   POWER
F9   ZQ   NC
G1   VDDQ   POWER
G2   DQ_D0   DQ   0.375   1.481nH   0.414pF   | 24.754   59.833
G3   LDQS_D_t   DQS   0.371   1.308nH   0.409pF   | 23.117   56.575
G7   VDD   POWER
G8   VSS   GND
G9   VDDQ   POWER
H1   VSS   GND
H2   DQ_D4   DQ   0.379   1.394nH   0.437pF   | 24.675   56.491
H3   DQ_D2   DQ   0.392   1.395nH   0.417pF   | 24.109   57.850
H7   DQ_D3   DQ   0.360   1.277nH   0.452pF   | 24.028   53.155
H8   DQ_D5   DQ   0.377   1.416nH   0.426pF   | 24.571   57.619
H9   VSS   GND
J1   VDDL   POWER
J2   VDDQ   POWER
J3   DQ_D6   DQ   0.390   1.403nH   0.430pF   | 24.558   57.139
J7   DQ_D7   DQ   0.378   1.364nH   0.462pF   | 25.109   54.336
J8   VDDQ   POWER
J9   VDD   POWER
K1   VSSL   GND
K2   CKE   INPUT   0.351   1.723nH   0.365pF   | 25.065   68.730
K3   ODT   INPUT   0.360   1.462nH   0.372pF   | 23.327   62.666
K7   CK_t   CLKIN   0.409   1.787nH   0.403pF   | 26.839   66.573
K8   CK_c   CLKIN   0.410   1.665nH   0.506pF   | 29.023   57.378
K9   VSS   GND
L1   VDD   POWER
L2   WE_n_A14   INPUT   0.487   2.355nH   0.479pF   | 33.583   70.132
L3   ACT_n   INPUT   0.451   2.143nH   0.390pF   | 28.914   74.106
L7   CS_n   INPUT   0.362   1.557nH   0.376pF   | 24.205   64.338
L8   RAS_n_A16   INPUT   0.477   2.317nH   0.489pF   | 33.674   68.805
L9   VDD   POWER
M1   VREFCA   POWER
M2   BG0   INPUT   0.479   2.369nH   0.515pF   | 34.945   67.806
M3   A10   INPUT   0.454   2.248nH   0.434pF   | 31.235   71.982
M7   A12_BC_n   INPUT   0.483   2.319nH   0.419pF   | 31.173   74.387
M8   CAS_n_A15   INPUT   0.478   2.348nH   0.480pF   | 33.562   69.951
M9   VSS   GND
N1   VSS   GND
N2   BA0   INPUT   0.479   2.374nH   0.512pF   | 34.857   68.103
N3   A4   INPUT   0.452   2.100nH   0.478pF   | 31.674   66.312
N7   A3   INPUT   0.450   2.185nH   0.410pF   | 29.934   72.983
N8   BA1   INPUT   0.459   2.323nH   0.470pF   | 33.052   70.281
N9   TEN   INPUT   0.492   2.634nH   0.554pF   | 38.186   68.973
P1   RESET_n   INPUT   0.521   2.658nH   0.645pF   | 41.422   64.175
P2   A6   INPUT   0.454   2.238nH   0.535pF   | 34.595   64.690
P3   A0   INPUT   0.464   2.127nH   0.477pF   | 31.865   66.738
P7   A1   INPUT   0.471   2.405nH   0.460pF   | 33.270   72.288
P8   A5   INPUT   0.486   2.545nH   0.504pF   | 35.814   71.053
P9   ALERT_n   ALERT   0.524   2.753nH   0.619pF   | 41.282   66.689
R1   VDD   POWER
R2   A8   INPUT   0.448   2.284nH   0.514pF   | 34.269   66.643
R3   A2   INPUT   0.486   2.382nH   0.508pF   | 34.785   68.473
R7   A9   INPUT   0.465   2.384nH   0.480pF   | 33.818   70.507
R8   A7   INPUT   0.490   2.582nH   0.538pF   | 37.258   69.301
R9   VPP   POWER
T1   VSS   GND
T2   A11   INPUT   0.487   2.401nH   0.569pF   | 36.954   64.970
T3   PARITY   INPUT   0.468   2.023nH   0.549pF   | 33.310   60.727
T7   NC   NC
T8   A13   INPUT   0.484   2.508nH   0.514pF   | 35.911   69.828
T9   VDD   POWER
|***********************PIN MAPPING*****************************************
[Pin Mapping]   pulldown_ref   pullup_ref   gnd_clamp_ref   power_clamp_ref ext_ref
A1   NC   VDDQ
A2   VSS   NC
A3   VSS   VDDQ   VSS   VDDQ
A7   VSS   VDDQ   VSS   VDDQ
A8   VSS   NC
A9   NC   VDDQ
B1   NC   VPP
B2   VSS   NC
B3   NC   VDD
B7   VSS   VDDQ   VSS   VDDQ
B8   VSS   VDDQ   VSS   VDDQ
B9   NC   VDD
C1   NC   VDDQ
C2   VSS   VDDQ   VSS   VDDQ
C3   VSS   VDDQ   VSS   VDDQ
C7   VSS   VDDQ   VSS   VDDQ
C8   VSS   VDDQ   VSS   VDDQ
C9   VSS   NC
D1   NC   VDD
D2   VSS   NC
D3   VSS   VDDQ   VSS   VDDQ
D7   VSS   VDDQ   VSS   VDDQ
D8   VSS   NC
D9   NC   VDDQ
E1   VSS   NC
E2   VSS   VDDQ   VSS   VDDQ
E3   VSS   NC
E7   VSS   VDDQ   VSS   VDDQ
E8   VSS   NC
E9   VSS   NC
F1   VSS   NC
F2   NC   VDDQ
F3   VSS   VDDQ   VSS   VDDQ
F7   VSS   VDDQ   VSS   VDDQ
F8   NC   VDDQ
F9   NC   NC
G1   NC   VDDQ
G2   VSS   VDDQ   VSS   VDDQ
G3   VSS   VDDQ   VSS   VDDQ
G7   NC   VDD
G8   VSS   NC
G9   NC   VDDQ
H1   VSS   NC
H2   VSS   VDDQ   VSS   VDDQ
H3   VSS   VDDQ   VSS   VDDQ
H7   VSS   VDDQ   VSS   VDDQ
H8   VSS   VDDQ   VSS   VDDQ
H9   VSS   NC
J1   NC   VDDL
J2   NC   VDDQ
J3   VSS   VDDQ   VSS   VDDQ
J7   VSS   VDDQ   VSS   VDDQ
J8   NC   VDDQ
J9   NC   VDD
K1   VSSL   NC
K2   NC   NC   VSS   VDD
K3   NC   NC   VSS   VDD
K7   NC   NC   VSS   VDD
K8   NC   NC   VSS   VDD
K9   VSS   NC
L1   NC   VDD
L2   NC   NC   VSS   VDD
L3   NC   NC   VSS   VDD
L7   NC   NC   VSS   VDD
L8   NC   NC   VSS   VDD
L9   NC   VDD
M1   NC   VREFCA
M2   NC   NC   VSS   VDD
M3   NC   NC   VSS   VDD
M7   NC   NC   VSS   VDD
M8   NC   NC   VSS   VDD
M9   VSS   NC
N1   VSS   NC
N2   NC   NC   VSS   VDD
N3   NC   NC   VSS   VDD
N7   NC   NC   VSS   VDD
N8   NC   NC   VSS   VDD
N9   NC   NC   VSS   VDD
P1   NC   NC   VSS   VDD
P2   NC   NC   VSS   VDD
P3   NC   NC   VSS   VDD
P7   NC   NC   VSS   VDD
P8   NC   NC   VSS   VDD
P9   VSS   VDDQ   VSS   VDDQ
R1   NC   VDD
R2   NC   NC   VSS   VDD
R3   NC   NC   VSS   VDD
R7   NC   NC   VSS   VDD
R8   NC   NC   VSS   VDD
R9   NC   VPP
T1   VSS   NC
T2   NC   NC   VSS   VDD
T3   NC   NC   VSS   VDD
T7   NC   NC
T8   NC   NC   VSS   VDD
T9   NC   VDD
|**********************DIFF PIN*********************************************
[Diff_pin]   inv_pin   vdiff   tdelay_typ   tdelay_min   tdelay_max
   B7   A7   0.000V   0ns   NA   NA
   G3   F3   0.000V   0ns   NA   NA
   K7   K8   0.250V   0ns   NA   NA
| COMPONENT: MT40A2G4Z11B (Bare Die, x4)
[Component]   MT40A2G4Z11B
[Manufacturer]  Micron Technology,Inc.
[Package]
|   typ   min   max
R_pkg   0.001   0.001   0.001
L_pkg   0.001nH   0.001nH   0.001nH
C_pkg   0.001pF   0.001pF   0.001pF
[Pin]   signal_name   model_name   R_pin   L_pin   C_pin
1   VDD   POWER
2   VSS   GND
3   VPP   POWER
4   VDDQ   POWER
5   NC   NC
6   VSS   GND
7   NC   NC
8   VDDQ   POWER
9   NC   NC
10   VSS   GND
11   VSS   GND
12   NC   NC
13   VDDQ   POWER
14   NC   NC
15   VSS   GND
16   VDDQ   POWER
17   VDD   POWER
18   VSS   GND
19   NC   NC
20   VDDQ   POWER
21   NC   NC
22   VSS   GND
23   VSS   GND
24   NC   NC
25   VDDQ   POWER
26   NC   NC
27   VSS   GND
28   VSS   GND
29   NC   NC
30   VDDQ   POWER
31   NC   NC
32   VSS   GND
33   VDD   POWER
34   VSS   GND
35   ZQ   NC
36   VDDQ   POWER
37   DQS_D_c   DQS
38   VSS   GND
39   DQS_D_t   DQS
40   VDDQ   POWER
41   NC   NC
42   VSS   GND
43   VSS   GND
44   DQ_D1   DQ
45   VDDQ   POWER
46   DQ_D3   DQ
47   VSS   GND
48   VDDQ   POWER
49   VDD   POWER
50   VSS   GND
51   DQ_D0   DQ
52   VDDQ   POWER
53   DQ_D2   DQ
54   VSS   GND
55   VSS   GND
56   NC   NC
57   VDDQ   POWER
58   NC   NC
59   VSS   GND
60   VSS   GND
61   NC   NC
62   VDDQ   POWER
63   NC   NC
64   VSS   GND
65   VDD   POWER
66   VSS   GND
67   VDD   POWER
68   VDDL   POWER
69   VSSL   GND
70   CK_t   CLKIN
71   CK_c   CLKIN
72   VSS   GND
73   VDD   POWER
74   ODT   INPUT
75   NC   NC
76   CS_n   INPUT
77   NC   NC
78   CKE   INPUT
79   NC   NC
80   RAS_n_A16   INPUT
81   WE_n_A14   INPUT
82   CAS_n_A15   INPUT
83   ACT_n   INPUT
84   BG1   INPUT
85   A10   INPUT
86   A12_BC_n   INPUT
87   BG0   INPUT
88   BA1   INPUT
89   BA0   INPUT
90   A3   INPUT
91   A4   INPUT
92   TEN   INPUT
93   VSS   GND
94   VREFCA   POWER
95   VDD   POWER
96   A5   INPUT
97   A0   INPUT
98   A1   INPUT
99   ALERT_n   ALERT
100   A6   INPUT
101   RESET_n   INPUT
102   A7   INPUT
103   A8   INPUT
104   A9   INPUT
105   A2   INPUT
106   A13   INPUT
107   A11   INPUT
108   PARITY   INPUT
109   VSS   GND
110   VDD   POWER
111   NC   NC
112   NC   NC
113   VPP   POWER
114   NC   NC
115   NC   NC
116   VDD   POWER
117   VSS   GND
|**************************************PIN MAPPING**************************************
[Pin Mapping]   pulldown_ref   pullup_ref   gnd_clamp_ref   power_clamp_ref  ext_ref
1   NC   VDD
2   VSS   NC
3   NC   VPP
4   NC   VDDQ
5   NC   NC
6   VSS   NC
7   NC   NC
8   NC   VDDQ
9   NC   NC
10   VSS   NC
11   VSS   NC
12   NC   NC
13   NC   VDDQ
14   NC   NC
15   VSS   NC
16   NC   VDDQ
17   NC   VDD
18   VSS   NC
19   NC   NC
20   NC   VDDQ
21   NC   NC
22   VSS   NC
23   VSS   NC
24   NC   NC
25   NC   VDDQ
26   NC   NC
27   VSS   NC
28   VSS   NC
29   NC   NC
30   NC   VDDQ
31   NC   NC
32   VSS   NC
33   NC   VDD
34   VSS   NC
35   NC   NC
36   NC   VDDQ
37   VSS   VDDQ   VSS   VDDQ
38   VSS   NC
39   VSS   VDDQ   VSS   VDDQ
40   NC   VDDQ
41   NC   NC
42   VSS   NC
43   VSS   NC
44   VSS   VDDQ   VSS   VDDQ
45   NC   VDDQ
46   VSS   VDDQ   VSS   VDDQ
47   VSS   NC
48   NC   VDDQ
49   NC   VDD
50   VSS   NC
51   VSS   VDDQ   VSS   VDDQ
52   NC   VDDQ
53   VSS   VDDQ   VSS   VDDQ
54   VSS   NC
55   VSS   NC
56   NC   NC
57   NC   VDDQ
58   NC   NC
59   VSS   NC
60   VSS   NC
61   NC   NC
62   NC   VDDQ
63   NC   NC
64   VSS   NC
65   NC   VDD
66   VSS   NC
67   NC   VDD
68   NC   VDDL
69   VSSL   NC
70   NC   NC   VSS   VDD
71   NC   NC   VSS   VDD
72   VSS   NC
73   NC   VDD
74   NC   NC   VSS   VDD
75   NC   NC
76   NC   NC   VSS   VDD
77   NC   NC
78   NC   NC   VSS   VDD
79   NC   NC
80   NC   NC   VSS   VDD
81   NC   NC   VSS   VDD
82   NC   NC   VSS   VDD
83   NC   NC   VSS   VDD
84   NC   NC
85   NC   NC   VSS   VDD
86   NC   NC   VSS   VDD
87   NC   NC   VSS   VDD
88   NC   NC   VSS   VDD
89   NC   NC   VSS   VDD
90   NC   NC   VSS   VDD
91   NC   NC   VSS   VDD
92   NC   NC   VSS   VDD
93   VSS   NC
94   NC   VREFCA
95   NC   VDD
96   NC   NC   VSS   VDD
97   NC   NC   VSS   VDD
98   NC   NC   VSS   VDD
99   VSS   VDDQ   VSS   VDDQ
100   NC   NC   VSS   VDD
101   NC   NC   VSS   VDD
102   NC   NC   VSS   VDD
103   NC   NC   VSS   VDD
104   NC   NC   VSS   VDD
105   NC   NC   VSS   VDD
106   NC   NC   VSS   VDD
107   NC   NC   VSS   VDD
108   NC   NC   VSS   VDD
109   VSS   NC
110   NC   VDD
111   NC   NC
112   NC   NC
113   NC   VPP
114   NC   NC
115   NC   NC
116   NC   VDD
117   VSS   NC
|**********************DIFF PIN*********************************************
[Diff_pin]   inv_pin   vdiff   tdelay_typ   tdelay_min   tdelay_max
   39   37   0.000V   0ns   NA   NA
   70   71   0.250V   0ns   NA   NA
| COMPONENT: MT40A1G8Z11B (Bare Die, x8)
[Component]   MT40A1G8Z11B
[Manufacturer]  Micron Technology,Inc.
[Package]
|   typ   min   max
R_pkg   0.001   0.001   0.001
L_pkg   0.001nH   0.001nH   0.001nH
C_pkg   0.001pF   0.001pF   0.001pF
[Pin]   signal_name   model_name   R_pin   L_pin   C_pin
1   VDD   POWER
2   VSS   GND
3   VPP   POWER
4   VDDQ   POWER
5   NC   NC
6   VSS   GND
7   NC   NC
8   VDDQ   POWER
9   NC   NC
10   VSS   GND
11   VSS   GND
12   NC   NC
13   VDDQ   POWER
14   NC   NC
15   VSS   GND
16   VDDQ   POWER
17   VDD   POWER
18   VSS   GND
19   NC   NC
20   VDDQ   POWER
21   NC   NC
22   VSS   GND
23   VSS   GND
24   NC   NC
25   VDDQ   POWER
26   NC   NC
27   VSS   GND
28   VSS   GND
29   NC   NC
30   VDDQ   POWER
31   NC   NC
32   VSS   GND
33   VDD   POWER
34   VSS   GND
35   ZQ   NC
36   VDDQ   POWER
37   DQS_D_c   DQS
38   VSS   GND
39   DQS_D_t   DQS
40   VDDQ   POWER
41   DM_n_DBI_n_TDQS_t  DM_DBI_TDQS_D
42   VSS   GND
43   VSS   GND
44   DQ_D1   DQ
45   VDDQ   POWER
46   DQ_D3   DQ
47   VSS   GND
48   VDDQ   POWER
49   VDD   POWER
50   VSS   GND
51   DQ_D0   DQ
52   VDDQ   POWER
53   DQ_D2   DQ
54   VSS   GND
55   VSS   GND
56   DQ_D5   DQ
57   VDDQ   POWER
58   DQ_D7   DQ
59   VSS   GND
60   VSS   GND
61   DQ_D4   DQ
62   VDDQ   POWER
63   DQ_D6   DQ
64   VSS   GND
65   VDD   POWER
66   VSS   GND
67   VDD   POWER
68   VDDL   POWER
69   VSSL   GND
70   CK_t   CLKIN
71   CK_c   CLKIN
72   VSS   GND
73   VDD   POWER
74   ODT   INPUT
75   NC   NC
76   CS_n   INPUT
77   NC   NC
78   CKE   INPUT
79   NC   NC
80   RAS_n_A16   INPUT
81   WE_n_A14   INPUT
82   CAS_n_A15   INPUT
83   ACT_n   INPUT
84   BG1   INPUT
85   A10   INPUT
86   A12_BC_n   INPUT
87   BG0   INPUT
88   BA1   INPUT
89   BA0   INPUT
90   A3   INPUT
91   A4   INPUT
92   TEN   INPUT
93   VSS   GND
94   VREFCA   POWER
95   VDD   POWER
96   A5   INPUT
97   A0   INPUT
98   A1   INPUT
99   ALERT_n   ALERT
100   A6   INPUT
101   RESET_n   INPUT
102   A7   INPUT
103   A8   INPUT
104   A9   INPUT
105   A2   INPUT
106   A13   INPUT
107   A11   INPUT
108   PARITY   INPUT
109   VSS   GND
110   VDD   POWER
111   NC   NC
112   NC   NC
113   VPP   POWER
114   NC   NC
115   NC   NC
116   VDD   POWER
117   VSS   GND
|**************************************PIN MAPPING**************************************
[Pin Mapping]   pulldown_ref   pullup_ref   gnd_clamp_ref   power_clamp_ref  ext_ref
1   NC   VDD
2   VSS   NC
3   NC   VPP
4   NC   VDDQ
5   NC   NC
6   VSS   NC
7   NC   NC
8   NC   VDDQ
9   NC   NC
10   VSS   NC
11   VSS   NC
12   NC   NC
13   NC   VDDQ
14   NC   NC
15   VSS   NC
16   NC   VDDQ
17   NC   VDD
18   VSS   NC
19   NC   NC
20   NC   VDDQ
21   NC   NC
22   VSS   NC
23   VSS   NC
24   NC   NC
25   NC   VDDQ
26   NC   NC
27   VSS   NC
28   VSS   NC
29   NC   NC
30   NC   VDDQ
31   NC   NC
32   VSS   NC
33   NC   VDD
34   VSS   NC
35   NC   NC
36   NC   VDDQ
37   VSS   VDDQ   VSS   VDDQ
38   VSS   NC
39   VSS   VDDQ   VSS   VDDQ
40   NC   VDDQ
41   VSS   VDDQ   VSS   VDDQ
42   VSS   NC
43   VSS   NC
44   VSS   VDDQ   VSS   VDDQ
45   NC   VDDQ
46   VSS   VDDQ   VSS   VDDQ
47   VSS   NC
48   NC   VDDQ
49   NC   VDD
50   VSS   NC
51   VSS   VDDQ   VSS   VDDQ
52   NC   VDDQ
53   VSS   VDDQ   VSS   VDDQ
54   VSS   NC
55   VSS   NC
56   VSS   VDDQ   VSS   VDDQ
57   NC   VDDQ
58   VSS   VDDQ   VSS   VDDQ
59   VSS   NC
60   VSS   NC
61   VSS   VDDQ   VSS   VDDQ
62   NC   VDDQ
63   VSS   VDDQ   VSS   VDDQ
64   VSS   NC
65   NC   VDD
66   VSS   NC
67   NC   VDD
68   NC   VDDL
69   VSSL   NC
70   NC   NC   VSS   VDD
71   NC   NC   VSS   VDD
72   VSS   NC
73   NC   VDD
74   NC   NC   VSS   VDD
75   NC   NC
76   NC   NC   VSS   VDD
77   NC   NC
78   NC   NC   VSS   VDD
79   NC   NC
80   NC   NC   VSS   VDD
81   NC   NC   VSS   VDD
82   NC   NC   VSS   VDD
83   NC   NC   VSS   VDD
84   NC   NC
85   NC   NC   VSS   VDD
86   NC   NC   VSS   VDD
87   NC   NC   VSS   VDD
88   NC   NC   VSS   VDD
89   NC   NC   VSS   VDD
90   NC   NC   VSS   VDD
91   NC   NC   VSS   VDD
92   NC   NC   VSS   VDD
93   VSS   NC
94   NC   VREFCA
95   NC   VDD
96   NC   NC   VSS   VDD
97   NC   NC   VSS   VDD
98   NC   NC   VSS   VDD
99   VSS   VDDQ   VSS   VDDQ
100   NC   NC   VSS   VDD
101   NC   NC   VSS   VDD
102   NC   NC   VSS   VDD
103   NC   NC   VSS   VDD
104   NC   NC   VSS   VDD
105   NC   NC   VSS   VDD
106   NC   NC   VSS   VDD
107   NC   NC   VSS   VDD
108   NC   NC   VSS   VDD
109   VSS   NC
110   NC   VDD
111   NC   NC
112   NC   NC
113   NC   VPP
114   NC   NC
115   NC   NC
116   NC   VDD
117   VSS   NC
|**********************DIFF PIN*********************************************
[Diff_pin]   inv_pin   vdiff   tdelay_typ   tdelay_min   tdelay_max
   39   37   0.000V   0ns   NA   NA
   70   71   0.250V   0ns   NA   NA
| COMPONENT: MT40A512M16Z11B (Bare Die, x16)
[Component]   MT40A512M16Z11B
[Manufacturer]  Micron Technology,Inc.
[Package]
|   typ   min   max
R_pkg   0.001   0.001   0.001
L_pkg   0.001nH   0.001nH   0.001nH
C_pkg   0.001pF   0.001pF   0.001pF
[Pin]   signal_name   model_name   R_pin   L_pin   C_pin
1   VDD   POWER
2   VSS   GND
3   VPP   POWER
4   VDDQ   POWER
5   UDQS_D_c   DQS
6   VSS   GND
7   UDQS_D_t   DQS
8   VDDQ   POWER
9   DQ_D8   DQ
10   VSS   GND
11   VSS   GND
12   DQ_D10   DQ
13   VDDQ   POWER
14   DQ_D12   DQ
15   VSS   GND
16   VDDQ   POWER
17   VDD   POWER
18   VSS   GND
19   DQ_D9   DQ
20   VDDQ   POWER
21   DQ_D11   DQ
22   VSS   GND
23   VSS   GND
24   DQ_D14   DQ
25   VDDQ   POWER
26   UDM_n_UDBI_n   DM_DBI_D
27   VSS   GND
28   VSS   GND
29   DQ_D13   DQ
30   VDDQ   POWER
31   DQ_D15   DQ
32   VSS   GND
33   VDD   POWER
34   VSS   GND
35   ZQ   NC
36   VDDQ   POWER
37   LDQS_D_c   DQS
38   VSS   GND
39   LDQS_D_t   DQS
40   VDDQ   POWER
41   LDM_n_LDBI_n   DM_DBI_D
42   VSS   GND
43   VSS   GND
44   DQ_D1   DQ
45   VDDQ   POWER
46   DQ_D3   DQ
47   VSS   GND
48   VDDQ   POWER
49   VDD   POWER
50   VSS   GND
51   DQ_D0   DQ
52   VDDQ   POWER
53   DQ_D2   DQ
54   VSS   GND
55   VSS   GND
56   DQ_D5   DQ
57   VDDQ   POWER
58   DQ_D7   DQ
59   VSS   GND
60   VSS   GND
61   DQ_D4   DQ
62   VDDQ   POWER
63   DQ_D6   DQ
64   VSS   GND
65   VDD   POWER
66   VSS   GND
67   VDD   POWER
68   VDDL   POWER
69   VSSL   GND
70   CK_t   CLKIN
71   CK_c   CLKIN
72   VSS   GND
73   VDD   POWER
74   ODT   INPUT
75   NC   NC
76   CS_n   INPUT
77   NC   NC
78   CKE   INPUT
79   NC   NC
80   RAS_n_A16   INPUT
81   WE_n_A14   INPUT
82   CAS_n_A15   INPUT
83   ACT_n   INPUT
84   NC   NC
85   A10   INPUT
86   A12_BC_n   INPUT
87   BG0   INPUT
88   BA1   INPUT
89   BA0   INPUT
90   A3   INPUT
91   A4   INPUT
92   TEN   INPUT
93   VSS   GND
94   VREFCA   POWER
95   VDD   POWER
96   A5   INPUT
97   A0   INPUT
98   A1   INPUT
99   ALERT_n   ALERT
100   A6   INPUT
101   RESET_n   INPUT
102   A7   INPUT
103   A8   INPUT
104   A9   INPUT
105   A2   INPUT
106   A13   INPUT
107   A11   INPUT
108   PARITY   INPUT
109   VSS   GND
110   VDD   POWER
111   NC   NC
112   NC   NC
113   VPP   POWER
114   NC   NC
115   NC   NC
116   VDD   POWER
117   VSS   GND
|**************************************PIN MAPPING**************************************
[Pin Mapping]   pulldown_ref   pullup_ref   gnd_clamp_ref   power_clamp_ref  ext_ref
1   NC   VDD
2   VSS   NC
3   NC   VPP
4   NC   VDDQ
5   VSS   VDDQ   VSS   VDDQ
6   VSS   NC
7   VSS   VDDQ   VSS   VDDQ
8   NC   VDDQ
9   VSS   VDDQ   VSS   VDDQ
10   VSS   NC
11   VSS   NC
12   VSS   VDDQ   VSS   VDDQ
13   NC   VDDQ
14   VSS   VDDQ   VSS   VDDQ
15   VSS   NC
16   NC   VDDQ
17   NC   VDD
18   VSS   NC
19   VSS   VDDQ   VSS   VDDQ
20   NC   VDDQ
21   VSS   VDDQ   VSS   VDDQ
22   VSS   NC
23   VSS   NC
24   VSS   VDDQ   VSS   VDDQ
25   NC   VDDQ
26   VSS   VDDQ   VSS   VDDQ
27   VSS   NC
28   VSS   NC
29   VSS   VDDQ   VSS   VDDQ
30   NC   VDDQ
31   VSS   VDDQ   VSS   VDDQ
32   VSS   NC
33   NC   VDD
34   VSS   NC
35   NC   NC
36   NC   VDDQ
37   VSS   VDDQ   VSS   VDDQ
38   VSS   NC
39   VSS   VDDQ   VSS   VDDQ
40   NC   VDDQ
41   VSS   VDDQ   VSS   VDDQ
42   VSS   NC
43   VSS   NC
44   VSS   VDDQ   VSS   VDDQ
45   NC   VDDQ
46   VSS   VDDQ   VSS   VDDQ
47   VSS   NC
48   NC   VDDQ
49   NC   VDD
50   VSS   NC
51   VSS   VDDQ   VSS   VDDQ
52   NC   VDDQ
53   VSS   VDDQ   VSS   VDDQ
54   VSS   NC
55   VSS   NC
56   VSS   VDDQ   VSS   VDDQ
57   NC   VDDQ
58   VSS   VDDQ   VSS   VDDQ
59   VSS   NC
60   VSS   NC
61   VSS   VDDQ   VSS   VDDQ
62   NC   VDDQ
63   VSS   VDDQ   VSS   VDDQ
64   VSS   NC
65   NC   VDD
66   VSS   NC
67   NC   VDD
68   NC   VDDL
69   VSSL   NC
70   NC   NC   VSS   VDD
71   NC   NC   VSS   VDD
72   VSS   NC
73   NC   VDD
74   NC   NC   VSS   VDD
75   NC   NC
76   NC   NC   VSS   VDD
77   NC   NC
78   NC   NC   VSS   VDD
79   NC   NC
80   NC   NC   VSS   VDD
81   NC   NC   VSS   VDD
82   NC   NC   VSS   VDD
83   NC   NC   VSS   VDD
84   NC   NC
85   NC   NC   VSS   VDD
86   NC   NC   VSS   VDD
87   NC   NC   VSS   VDD
88   NC   NC   VSS   VDD
89   NC   NC   VSS   VDD
90   NC   NC   VSS   VDD
91   NC   NC   VSS   VDD
92   NC   NC   VSS   VDD
93   VSS   NC
94   NC   VREFCA
95   NC   VDD
96   NC   NC   VSS   VDD
97   NC   NC   VSS   VDD
98   NC   NC   VSS   VDD
99   VSS   VDDQ   VSS   VDDQ
100   NC   NC   VSS   VDD
101   NC   NC   VSS   VDD
102   NC   NC   VSS   VDD
103   NC   NC   VSS   VDD
104   NC   NC   VSS   VDD
105   NC   NC   VSS   VDD
106   NC   NC   VSS   VDD
107   NC   NC   VSS   VDD
108   NC   NC   VSS   VDD
109   VSS   NC
110   NC   VDD
111   NC   NC
112   NC   NC
113   NC   VPP
114   NC   NC
115   NC   NC
116   NC   VDD
117   VSS   NC
|**********************DIFF PIN*********************************************
[Diff_pin]   inv_pin   vdiff   tdelay_typ   tdelay_min   tdelay_max
   7   5   0.000V   0ns   NA   NA
   39   37   0.000V   0ns   NA   NA
   70   71   0.250V   0ns   NA   NA
|   Model Selector
[Model Selector] DQ_D
DQ_34_3200   34 Ohm Data I/O with no ODT, 1600-3200Mbps
DQ_40_3200   40 Ohm Data I/O with no ODT, 1600-3200Mbps
DQ_48_3200   48 Ohm Data I/O with no ODT, 1600-3200Mbps
DQ_IN_ODTOFF_3200  Data Input with no ODT, 1600-3200Mbps
DQ_IN_ODT34_3200   Data Input with 34ohm ODT, 1600-3200Mbps
DQ_IN_ODT40_3200   Data Input with 40ohm ODT, 1600-3200Mbps
DQ_IN_ODT48_3200   Data Input with 48ohm ODT, 1600-3200Mbps
DQ_IN_ODT60_3200   Data Input with 60ohm ODT, 1600-3200Mbps
DQ_IN_ODT80_3200   Data Input with 80ohm ODT, 1600-3200Mbps
DQ_IN_ODT120_3200  Data Input with 120ohm ODT, 1600-3200Mbps
DQ_IN_ODT240_3200  Data Input with 240ohm ODT, 1600-3200Mbps
[Model Selector] DQ
DQ_34_3200   34 Ohm Data I/O with no ODT, 1600-3200Mbps
DQ_40_3200   40 Ohm Data I/O with no ODT, 1600-3200Mbps
DQ_48_3200   48 Ohm Data I/O with no ODT, 1600-3200Mbps
DQ_IN_ODTOFF_3200  Data Input with no ODT, 1600-3200Mbps
DQ_IN_ODT34_3200   Data Input with 34ohm ODT, 1600-3200Mbps
DQ_IN_ODT40_3200   Data Input with 40ohm ODT, 1600-3200Mbps
DQ_IN_ODT48_3200   Data Input with 48ohm ODT, 1600-3200Mbps
DQ_IN_ODT60_3200   Data Input with 60ohm ODT, 1600-3200Mbps
DQ_IN_ODT80_3200   Data Input with 80ohm ODT, 1600-3200Mbps
DQ_IN_ODT120_3200  Data Input with 120ohm ODT, 1600-3200Mbps
DQ_IN_ODT240_3200  Data Input with 240ohm ODT, 1600-3200Mbps
[Model Selector] DQS_D
DQS_34_3200   34 Ohm Data Strobe I/O with no ODT, 1600-3200Mbps
DQS_40_3200   40 Ohm Data Strobe I/O with no ODT, 1600-3200Mbps
DQS_48_3200   48 Ohm Data Strobe I/O with no ODT, 1600-3200Mbps
DQS_IN_ODTOFF_3200 Data Strobe Input with no ODT, 1600-3200Mbps
DQS_IN_ODT34_3200  Data Strobe Input with 34ohm ODT, 1600-3200Mbps
DQS_IN_ODT40_3200  Data Strobe Input with 40ohm ODT, 1600-3200Mbps
DQS_IN_ODT48_3200  Data Strobe Input with 48ohm ODT, 1600-3200Mbps
DQS_IN_ODT60_3200  Data Strobe Input with 60ohm ODT, 1600-3200Mbps
DQS_IN_ODT80_3200  Data Strobe Input with 80ohm ODT, 1600-3200Mbps
DQS_IN_ODT120_3200 Data Strobe Input with 120ohm ODT, 1600-3200Mbps
DQS_IN_ODT240_3200 Data Strobe Input with 240ohm ODT, 1600-3200Mbps
[Model Selector] DQS
DQS_34_3200   34 Ohm Data Strobe I/O with no ODT, 1600-3200Mbps
DQS_40_3200   40 Ohm Data Strobe I/O with no ODT, 1600-3200Mbps
DQS_48_3200   48 Ohm Data Strobe I/O with no ODT, 1600-3200Mbps
DQS_IN_ODTOFF_3200 Data Strobe Input with no ODT, 1600-3200Mbps
DQS_IN_ODT34_3200  Data Strobe Input with 34ohm ODT, 1600-3200Mbps
DQS_IN_ODT40_3200  Data Strobe Input with 40ohm ODT, 1600-3200Mbps
DQS_IN_ODT48_3200  Data Strobe Input with 48ohm ODT, 1600-3200Mbps
DQS_IN_ODT60_3200  Data Strobe Input with 60ohm ODT, 1600-3200Mbps
DQS_IN_ODT80_3200  Data Strobe Input with 80ohm ODT, 1600-3200Mbps
DQS_IN_ODT120_3200 Data Strobe Input with 120ohm ODT, 1600-3200Mbps
DQS_IN_ODT240_3200 Data Strobe Input with 240ohm ODT, 1600-3200Mbps
[Model Selector] DM_DBI_D
DM_ODTOFF_3200   DM Input Model with no ODT, 1600-3200Mbps
DM_ODT34_3200   DM Input Model with 34ohm ODT, 1600-3200Mbps
DM_ODT40_3200   DM Input Model with 40ohm ODT, 1600-3200Mbps
DM_ODT48_3200   DM Input Model with 48ohm ODT, 1600-3200Mbps
DM_ODT60_3200   DM Input Model with 60ohm ODT, 1600-3200Mbps
DM_ODT80_3200   DM Input Model with 80ohm ODT, 1600-3200Mbps
DM_ODT120_3200   DM Input Model with 120ohm ODT, 1600-3200Mbps
DM_ODT240_3200   DM Input Model with 240ohm ODT, 1600-3200Mbps
DQ_34_3200   34 Ohm DBI I/O with no ODT, 1600-3200Mbps
DQ_40_3200   40 Ohm DBI I/O with no ODT, 1600-3200Mbps
DQ_48_3200   48 Ohm DBI I/O with no ODT, 1600-3200Mbps
DQ_IN_ODTOFF_3200  DBI Input with no ODT, 1600-3200Mbps
DQ_IN_ODT34_3200   DBI Input with 34ohm ODT, 1600-3200Mbps
DQ_IN_ODT40_3200   DBI Input with 40ohm ODT, 1600-3200Mbps
DQ_IN_ODT48_3200   DBI Input with 48ohm ODT, 1600-3200Mbps
DQ_IN_ODT60_3200   DBI Input with 60ohm ODT, 1600-3200Mbps
DQ_IN_ODT80_3200   DBI Input with 80ohm ODT, 1600-3200Mbps
DQ_IN_ODT120_3200  DBI Input with 120ohm ODT, 1600-3200Mbps
DQ_IN_ODT240_3200  DBI Input with 240ohm ODT, 1600-3200Mbps
NF_DQ   Non-Functioning DQ Terminator Model
[Model Selector] DM_DBI
DM_ODTOFF_3200   DM Input Model with no ODT, 1600-3200Mbps
DM_ODT34_3200   DM Input Model with 34ohm ODT, 1600-3200Mbps
DM_ODT40_3200   DM Input Model with 40ohm ODT, 1600-3200Mbps
DM_ODT48_3200   DM Input Model with 48ohm ODT, 1600-3200Mbps
DM_ODT60_3200   DM Input Model with 60ohm ODT, 1600-3200Mbps
DM_ODT80_3200   DM Input Model with 80ohm ODT, 1600-3200Mbps
DM_ODT120_3200   DM Input Model with 120ohm ODT, 1600-3200Mbps
DM_ODT240_3200   DM Input Model with 240ohm ODT, 1600-3200Mbps
DQ_34_3200   34 Ohm DBI I/O with no ODT, 1600-3200Mbps
DQ_40_3200   40 Ohm DBI I/O with no ODT, 1600-3200Mbps
DQ_48_3200   48 Ohm DBI I/O with no ODT, 1600-3200Mbps
DQ_IN_ODTOFF_3200  DBI Input with no ODT, 1600-3200Mbps
DQ_IN_ODT34_3200   DBI Input with 34ohm ODT, 1600-3200Mbps
DQ_IN_ODT40_3200   DBI Input with 40ohm ODT, 1600-3200Mbps
DQ_IN_ODT48_3200   DBI Input with 48ohm ODT, 1600-3200Mbps
DQ_IN_ODT60_3200   DBI Input with 60ohm ODT, 1600-3200Mbps
DQ_IN_ODT80_3200   DBI Input with 80ohm ODT, 1600-3200Mbps
DQ_IN_ODT120_3200  DBI Input with 120ohm ODT, 1600-3200Mbps
DQ_IN_ODT240_3200  DBI Input with 240ohm ODT, 1600-3200Mbps
NF_DQ   Non-Functioning DQ Terminator Model
[Model Selector] DM_DBI_TDQS_D
DM_ODTOFF_3200   DM Input Model with no ODT, 1600-3200Mbps
DM_ODT34_3200   DM Input Model with 34ohm ODT, 1600-3200Mbps
DM_ODT40_3200   DM Input Model with 40ohm ODT, 1600-3200Mbps
DM_ODT48_3200   DM Input Model with 48ohm ODT, 1600-3200Mbps
DM_ODT60_3200   DM Input Model with 60ohm ODT, 1600-3200Mbps
DM_ODT80_3200   DM Input Model with 80ohm ODT, 1600-3200Mbps
DM_ODT120_3200   DM Input Model with 120ohm ODT, 1600-3200Mbps
DM_ODT240_3200   DM Input Model with 240ohm ODT, 1600-3200Mbps
DQ_34_3200   34 Ohm DBI I/O with no ODT, 1600-3200Mbps
DQ_40_3200   40 Ohm DBI I/O with no ODT, 1600-3200Mbps
DQ_48_3200   48 Ohm DBI I/O with no ODT, 1600-3200Mbps
DQ_IN_ODTOFF_3200  DBI Input with no ODT, 1600-3200Mbps
DQ_IN_ODT34_3200   DBI Input with 34ohm ODT, 1600-3200Mbps
DQ_IN_ODT40_3200   DBI Input with 40ohm ODT, 1600-3200Mbps
DQ_IN_ODT48_3200   DBI Input with 48ohm ODT, 1600-3200Mbps
DQ_IN_ODT60_3200   DBI Input with 60ohm ODT, 1600-3200Mbps
DQ_IN_ODT80_3200   DBI Input with 80ohm ODT, 1600-3200Mbps
DQ_IN_ODT120_3200  DBI Input with 120ohm ODT, 1600-3200Mbps
DQ_IN_ODT240_3200  DBI Input with 240ohm ODT, 1600-3200Mbps
TDQS_ODTOFF_3200   TDQS Terminator Model with no ODT, 1600-3200Mbps
TDQS_ODT34_3200   TDQS Terminator Model with 34ohm ODT, 1600-3200Mbps
TDQS_ODT40_3200   TDQS Terminator Model with 40ohm ODT, 1600-3200Mbps
TDQS_ODT48_3200   TDQS Terminator Model with 48ohm ODT, 1600-3200Mbps
TDQS_ODT60_3200   TDQS Terminator Model with 60ohm ODT, 1600-3200Mbps
TDQS_ODT80_3200   TDQS Terminator Model with 80ohm ODT, 1600-3200Mbps
TDQS_ODT120_3200   TDQS Terminator Model with 120ohm ODT, 1600-3200Mbps
TDQS_ODT240_3200   TDQS Terminator Model with 240ohm ODT, 1600-3200Mbps
NF_DQ   Non-Functioning DQ Terminator Model
[Model Selector] DM_DBI_TDQS
DM_ODTOFF_3200   DM Input Model with no ODT, 1600-3200Mbps
DM_ODT34_3200   DM Input Model with 34ohm ODT, 1600-3200Mbps
DM_ODT40_3200   DM Input Model with 40ohm ODT, 1600-3200Mbps
DM_ODT48_3200   DM Input Model with 48ohm ODT, 1600-3200Mbps
DM_ODT60_3200   DM Input Model with 60ohm ODT, 1600-3200Mbps
DM_ODT80_3200   DM Input Model with 80ohm ODT, 1600-3200Mbps
DM_ODT120_3200   DM Input Model with 120ohm ODT, 1600-3200Mbps
DM_ODT240_3200   DM Input Model with 240ohm ODT, 1600-3200Mbps
DQ_34_3200   34 Ohm DBI I/O with no ODT, 1600-3200Mbps
DQ_40_3200   40 Ohm DBI I/O with no ODT, 1600-3200Mbps
DQ_48_3200   48 Ohm DBI I/O with no ODT, 1600-3200Mbps
DQ_IN_ODTOFF_3200  DBI Input with no ODT, 1600-3200Mbps
DQ_IN_ODT34_3200   DBI Input with 34ohm ODT, 1600-3200Mbps
DQ_IN_ODT40_3200   DBI Input with 40ohm ODT, 1600-3200Mbps
DQ_IN_ODT48_3200   DBI Input with 48ohm ODT, 1600-3200Mbps
DQ_IN_ODT60_3200   DBI Input with 60ohm ODT, 1600-3200Mbps
DQ_IN_ODT80_3200   DBI Input with 80ohm ODT, 1600-3200Mbps
DQ_IN_ODT120_3200  DBI Input with 120ohm ODT, 1600-3200Mbps
DQ_IN_ODT240_3200  DBI Input with 240ohm ODT, 1600-3200Mbps
TDQS_ODTOFF_3200   TDQS Terminator Model with no ODT, 1600-3200Mbps
TDQS_ODT34_3200   TDQS Terminator Model with 34ohm ODT, 1600-3200Mbps
TDQS_ODT40_3200   TDQS Terminator Model with 40ohm ODT, 1600-3200Mbps
TDQS_ODT48_3200   TDQS Terminator Model with 48ohm ODT, 1600-3200Mbps
TDQS_ODT60_3200   TDQS Terminator Model with 60ohm ODT, 1600-3200Mbps
TDQS_ODT80_3200   TDQS Terminator Model with 80ohm ODT, 1600-3200Mbps
TDQS_ODT120_3200   TDQS Terminator Model with 120ohm ODT, 1600-3200Mbps
TDQS_ODT240_3200   TDQS Terminator Model with 240ohm ODT, 1600-3200Mbps
NF_DQ   Non-Functioning DQ Terminator Model
[Model Selector] TDQS_D
TDQS_ODTOFF_3200   TDQS Terminator Model with no ODT, 1600-3200Mbps
TDQS_ODT34_3200   TDQS Terminator Model with 34ohm ODT, 1600-3200Mbps
TDQS_ODT40_3200   TDQS Terminator Model with 40ohm ODT, 1600-3200Mbps
TDQS_ODT48_3200   TDQS Terminator Model with 48ohm ODT, 1600-3200Mbps
TDQS_ODT60_3200   TDQS Terminator Model with 60ohm ODT, 1600-3200Mbps
TDQS_ODT80_3200   TDQS Terminator Model with 80ohm ODT, 1600-3200Mbps
TDQS_ODT120_3200   TDQS Terminator Model with 120ohm ODT, 1600-3200Mbps
TDQS_ODT240_3200   TDQS Terminator Model with 240ohm ODT, 1600-3200Mbps
NF_DQ   Non-Functioning DQ Terminator Model
[Model Selector] TDQS
TDQS_ODTOFF_3200   TDQS Terminator Model with no ODT, 1600-3200Mbps
TDQS_ODT34_3200   TDQS Terminator Model with 34ohm ODT, 1600-3200Mbps
TDQS_ODT40_3200   TDQS Terminator Model with 40ohm ODT, 1600-3200Mbps
TDQS_ODT48_3200   TDQS Terminator Model with 48ohm ODT, 1600-3200Mbps
TDQS_ODT60_3200   TDQS Terminator Model with 60ohm ODT, 1600-3200Mbps
TDQS_ODT80_3200   TDQS Terminator Model with 80ohm ODT, 1600-3200Mbps
TDQS_ODT120_3200   TDQS Terminator Model with 120ohm ODT, 1600-3200Mbps
TDQS_ODT240_3200   TDQS Terminator Model with 240ohm ODT, 1600-3200Mbps
NF_DQ   Non-Functioning DQ Terminator Model
| Sparse Matrix Package Model for z11b_78ball_pkg (x4/x8)
[Define Package Model]  z11b_78ball_pkg
[Manufacturer]   Micron Technology, Inc.
[OEM]   Micron Technology, Inc.
[Description]   z11b package model for 78-ball x4/x8 FBGA
[Number of Pins]   51
[Pin Numbers]
L3  | A0
L7  | A1
M3  | A2
K7  | A3
K3  | A4
L8  | A5
L2  | A6
M8  | A7
M2  | A8
M7  | A9
J3  | A10
N2  | A11
J7  | A12
N8  | A13
H3  | ACT#
L9  | ALERT#
K2  | BA0
K8  | BA1
J2  | BG0
J8  | BG1
H7  | CAS#
G3  | CKE
F8  | CK_C
F7  | CK_T
G7  | CS#
F3  | ODT
N3  | PARITY
H8  | RAS#
L1  | RESET#
H2  | WE#
C2  | DQ0
D3  | DQ2
D2  | DQ4
E3  | DQ6
B3  | DQS-C
C3  | DQS-T
A3  | TDQS-C
A7  | DM#
B7  | DQ1
D7  | DQ3
D8  | DQ5
E7  | DQ7
G9  | TEN
A1  | VDD
B2  | VDDQ_SUBNET_0
B8  | VDDQ_SUBNET_1
B1  | VPP-B1
M9  | VPP-M9
J1  | VREFCA
A9  | VSS
B9  | ZQ
[Model Data]
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[End Model Data]
[End Package Model]
| Sparse Matrix Package Model for z11b_96ball_pkg (x16)
[Define Package Model]  z11b_96ball_pkg
[Manufacturer]   Micron Technology, Inc.
[OEM]   Micron Technology, Inc.
[Description]   z11b package model for 96-ball x16 FBGA
[Number of Pins]   60
[Pin Numbers]
P3  | A0
P7  | A1
R3  | A2
N7  | A3
N3  | A4
P8  | A5
P2  | A6
R8  | A7
R2  | A8
R7  | A9
M3  | A10
T2  | A11
M7  | A12
T8  | A13
L3  | ACT#
P9  | ALERT#
N2  | BA0
N8  | BA1
M2  | BG0
M8  | CAS#
K2  | CKE
K8  | CK_C
K7  | CK_T
L7  | CS#
K3  | ODT
T3  | PARITY
L8  | RAS#
P1  | RESET#
L2  | WE#
G2  | DQ0
F7  | DQ1
H3  | DQ2
H7  | DQ3
H2  | DQ4
H8  | DQ5
J3  | DQ6
J7  | DQ7
A3  | DQ8
B8  | DQ9
C3  | DQ10
C7  | DQ11
C2  | DQ12
C8  | DQ13
D3  | DQ14
D7  | DQ15
E7  | LDM#
F3  | LDQS-C
G3  | LDQS-T
E2  | UDM#
A7  | UDQS-C
B7  | UDQS-T
F9  | ZQ
N9  | TEN
B3  | VDD
J1  | VDDDLL
A9  | VDDQ
B1  | VPP-B1
R9  | VPP-R9
M1  | VREFCA
B2  | VSS
[Model Data]
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[End Model Data]
[End Package Model]
| Models and submodels in the file (49): DQ_34_3200 (I/O), DQ_40_3200 (I/O), DQ_48_3200 (I/O), DQ_IN_ODTOFF_3200 (Input), DQ_IN_ODT34_3200 (Input), DQ_IN_ODT40_3200 (Input), DQ_IN_ODT48_3200 (Input), DQ_IN_ODT60_3200 (Input), DQ_IN_ODT80_3200 (Input), DQ_IN_ODT120_3200 (Input), DQ_IN_ODT240_3200 (Input), DQS_34_3200 (I/O), DQS_40_3200 (I/O), DQS_48_3200 (I/O), DQS_IN_ODTOFF_3200 (Input), DQS_IN_ODT34_3200 (Input), DQS_IN_ODT40_3200 (Input), DQS_IN_ODT48_3200 (Input), DQS_IN_ODT60_3200 (Input), DQS_IN_ODT80_3200 (Input), DQS_IN_ODT120_3200 (Input), DQS_IN_ODT240_3200 (Input), DM_ODTOFF_3200 (Input), DM_ODT34_3200 (Input), DM_ODT40_3200 (Input), DM_ODT48_3200 (Input), DM_ODT60_3200 (Input), DM_ODT80_3200 (Input), DM_ODT120_3200 (Input), DM_ODT240_3200 (Input), TDQS_ODTOFF_3200 (Terminator), TDQS_ODT34_3200 (Terminator), TDQS_ODT40_3200 (Terminator), TDQS_ODT48_3200 (Terminator), TDQS_ODT60_3200 (Terminator), TDQS_ODT80_3200 (Terminator), TDQS_ODT120_3200 (Terminator), TDQS_ODT240_3200 (Terminator), INPUT (Input), CLKIN (Input), ALERT (Open_sink), NF_DQ (Terminator), 34ohm_ODT_3200 (Dynamic_clamp), 40ohm_ODT_3200 (Dynamic_clamp), 48ohm_ODT_3200 (Dynamic_clamp), 60ohm_ODT_3200 (Dynamic_clamp), 80ohm_ODT_3200 (Dynamic_clamp), 120ohm_ODT_3200 (Dynamic_clamp), 240ohm_ODT_3200 (Dynamic_clamp)
